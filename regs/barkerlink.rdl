// BarkerLink CSR map - SINGLE SOURCE OF TRUTH.
// PeakRDL generates the APB3 CSR block RTL (Phase 2), the C/Python headers (fw/),
// and the register-map documentation from this file. `make regs` validates it and
// regenerates the HTML + C header. See docs/SPEC.md section 5.

addrmap barkerlink {
    name = "BarkerLink DSSS baseband CSRs";
    desc = "802.11b-class DSSS baseband transceiver control/status registers (APB3).";

    default regwidth = 32;
    default sw = rw;
    default hw = r;

    reg {
        name = "ID";
        desc = "Identification / version (read-only).";
        field {sw=r; hw=r; desc="ASCII 'BL' magic.";}   MAGIC[31:16] = 0x424C;
        field {sw=r; hw=r; desc="Major version.";}      VER_MAJ[15:8] = 0x01;
        field {sw=r; hw=r; desc="Minor version.";}      VER_MIN[7:0]  = 0x00;
    } ID @ 0x00;

    reg {
        name = "CTRL";
        desc = "Global control.";
        field {desc="Core enable.";}                        EN[0:0] = 0;
        field {singlepulse; desc="Start one TX frame (self-clearing).";} TX_START[1:1] = 0;
        field {desc="Receiver enable.";}                    RX_EN[2:2] = 0;
        field {desc="Internal digital TX->RX loopback.";}   LOOPBACK[3:3] = 0;
        field {desc="0=DBPSK 1 Mbps, 1=DQPSK 2 Mbps (P1).";} MODE[4:4] = 0;
        field {desc="Noise injector enable (P1).";}         NOISE_EN[5:5] = 0;
        field {singlepulse; desc="Soft reset (self-clearing).";} SOFT_RST[8:8] = 0;
    } CTRL @ 0x04;

    reg {
        name = "STATUS";
        desc = "Live status (read-only, hardware-driven).";
        field {sw=r; hw=w; desc="TX in progress.";}     TX_BUSY[0:0] = 0;
        field {sw=r; hw=w; desc="RX in progress.";}     RX_BUSY[1:1] = 0;
        field {sw=r; hw=w; desc="SFD detected.";}       SFD_DET[2:2] = 0;
        field {sw=r; hw=w; desc="Last header CRC ok.";} CRC_OK[3:3] = 0;
        field {sw=r; hw=w; desc="Carrier sense / CCA.";} CCA[4:4] = 0;
        field {sw=r; hw=w; desc="TX FIFO full.";}       TX_FULL[5:5] = 0;
        field {sw=r; hw=w; desc="TX FIFO empty.";}      TX_EMPTY[6:6] = 1;
        field {sw=r; hw=w; desc="RX FIFO full.";}       RX_FULL[7:7] = 0;
        field {sw=r; hw=w; desc="RX FIFO empty.";}      RX_EMPTY[8:8] = 1;
    } STATUS @ 0x08;

    reg {
        name = "IRQ_EN";
        desc = "Interrupt enable mask.";
        field {desc="TX done.";}             TX_DONE[0:0] = 0;
        field {desc="RX done.";}             RX_DONE[1:1] = 0;
        field {desc="SFD detected.";}        SFD[2:2] = 0;
        field {desc="Header CRC error.";}    CRC_ERR[3:3] = 0;
        field {desc="RX FIFO threshold.";}   RX_FIFO[4:4] = 0;
        field {desc="CCA change.";}          CCA[5:5] = 0;
    } IRQ_EN @ 0x0C;

    reg {
        name = "IRQ_STATUS";
        desc = "Interrupt status; write 1 to clear, hardware sets.";
        field {sw=rw; hw=w; we; woclr; desc="TX done.";}          TX_DONE[0:0] = 0;
        field {sw=rw; hw=w; we; woclr; desc="RX done.";}          RX_DONE[1:1] = 0;
        field {sw=rw; hw=w; we; woclr; desc="SFD detected.";}     SFD[2:2] = 0;
        field {sw=rw; hw=w; we; woclr; desc="Header CRC error.";} CRC_ERR[3:3] = 0;
        field {sw=rw; hw=w; we; woclr; desc="RX FIFO threshold.";} RX_FIFO[4:4] = 0;
        field {sw=rw; hw=w; we; woclr; desc="CCA change.";}       CCA[5:5] = 0;
    } IRQ_STATUS @ 0x10;

    reg {
        name = "TX_FIFO";
        desc = "TX data FIFO write port.";
        field {sw=w; hw=r; desc="PSDU byte in.";} DATA[7:0] = 0;
    } TX_FIFO @ 0x14;

    reg {
        name = "RX_FIFO";
        desc = "RX data FIFO read port.";
        field {sw=r; hw=w; desc="PSDU byte out.";} DATA[7:0] = 0;
    } RX_FIFO @ 0x18;

    reg {
        name = "FIFO_LVL";
        desc = "FIFO occupancy (0..16).";
        field {sw=r; hw=w; desc="TX FIFO level.";} TX_LVL[4:0] = 0;
        field {sw=r; hw=w; desc="RX FIFO level.";} RX_LVL[12:8] = 0;
    } FIFO_LVL @ 0x1C;

    reg {
        name = "TXCFG";
        desc = "TX framing configuration.";
        field {desc="PLCP SIGNAL byte (rate code).";} SIGNAL[7:0] = 0x0A;
        field {desc="PLCP SERVICE byte.";}            SERVICE[15:8] = 0x00;
        field {desc="PSDU length in octets.";}        LENGTH[31:16] = 0;
    } TXCFG @ 0x20;

    reg {
        name = "RXSTAT";
        desc = "Last received PLCP header (read-only).";
        field {sw=r; hw=w; desc="Received SIGNAL.";}  SIGNAL[7:0] = 0;
        field {sw=r; hw=w; desc="Received SERVICE.";} SERVICE[15:8] = 0;
        field {sw=r; hw=w; desc="Received LENGTH.";}  LENGTH[31:16] = 0;
    } RXSTAT @ 0x24;

    reg {
        name = "NOISE";
        desc = "On-chip LFSR noise injector (P1).";
        field {desc="Chip-flip probability, unsigned Q16 fraction.";} PROB[15:0] = 0;
    } NOISE @ 0x28;

    reg {
        name = "CCA_CFG";
        desc = "CCA / energy-detect configuration (P1).";
        field {desc="Correlation-magnitude threshold.";} THRESH[7:0] = 0x20;
    } CCA_CFG @ 0x2C;

    reg {
        name = "RSSI";
        desc = "RSSI proxy (P1, read-only).";
        field {sw=r; hw=w; desc="Peak correlation-magnitude proxy.";} VALUE[7:0] = 0;
    } RSSI @ 0x30;

    reg {
        name = "TEST";
        desc = "DFT / test mode (P6).";
        field {desc="Scan-chain enable.";}        SCAN_EN[0:0] = 0;
        field {desc="Route test mode onto uio.";} TEST_MODE[1:1] = 0;
    } TEST @ 0x34;
};
